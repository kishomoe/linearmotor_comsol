# Ansys Electronics Desktop project, version 2023.1
materials:
  vacuum: permittivity=1
  ChinaSteel_35CS210: permeability{HUnit=A_per_meter BUnit=tesla curve (0, 0) (20, 0.1065) (20.8512, 0.1159) (21.7386, 0.1266) (22.6638, 0.1388) (23.6283, 0.1526) (24.6339, 0.168) (25.6824, 0.1851) (26.7754, 0.2039) (27.9149, 0.2246) (29.103, 0.2472) (30.3416, 0.2717) (31.6329, 0.298) (32.9792, 0.3262) (34.3827, 0.3563) (35.846, 0.3881) (37.3716, 0.4214) (38.9621, 0.4561) (40.6204, 0.4918) (42.3491, 0.5284) (44.1515, 0.5654) (46.0305, 0.6027) (47.9896, 0.6399) (50.032, 0.6765) (52.1613, 0.712) (54.3813, 0.7464) (56.6957, 0.7795) (59.1086, 0.8113) (61.6243, 0.8418) (64.2469, 0.8709) (66.9813, 0.8982) (69.8319, 0.9235) (72.8039, 0.9467) (75.9024, 0.9684) (79.1328, 0.9897) (82.5006, 1.0121) (86.0118, 1.0351) (89.6724, 1.0572) (93.4888, 1.0766) (97.4677, 1.0938) (101.616, 1.1102) (105.941, 1.1262) (110.449, 1.1413) (115.15, 1.1549) (120.051, 1.1678) (125.16, 1.1811) (130.487, 1.1944) (136.04, 1.2071) (141.83, 1.2188) (147.866, 1.2293) (154.159, 1.2397) (160.72, 1.2498) (167.56, 1.259) (174.691, 1.2684) (182.126, 1.2774) (189.878, 1.2853) (197.958, 1.2932) (206.384, 1.301) (215.167, 1.3084) (224.325, 1.3155) (233.872, 1.3225) (243.825, 1.3292) (254.202, 1.3354) (265.021, 1.3414) (276.3, 1.3472) (288.059, 1.3529) (300.319, 1.3584) (313.1, 1.3636) (326.425, 1.3687) (340.318, 1.3741) (354.801, 1.3794) (369.902, 1.3842) (385.644, 1.3884) (402.057, 1.3927) (419.169, 1.3976) (437.008, 1.4028) (455.607, 1.4057) (474.997, 1.4073) (495.213, 1.4143) (516.289, 1.4205) (538.262, 1.4237) (561.17, 1.4267) (585.053, 1.4307) (609.952, 1.4349) (635.912, 1.4388) (662.976, 1.4427) (691.191, 1.4466) (720.608, 1.4505) (751.277, 1.4543) (783.251, 1.4582) (816.585, 1.462) (851.339, 1.4657) (887.571, 1.4698) (925.346, 1.4734) (964.728, 1.477) (1005.79, 1.4813) (1048.59, 1.4856) (1093.22, 1.4898) (1139.75, 1.494) (1188.25, 1.498) (1238.82, 1.502) (1291.55, 1.5059) (1346.52, 1.5098) (1403.82, 1.5137) (1463.57, 1.5176) (1525.86, 1.5215) (1590.8, 1.5256) (1658.5, 1.5298) (1729.08, 1.5342) (1802.67, 1.5386) (1879.39, 1.5431) (1959.38, 1.5477) (2042.77, 1.5524) (2129.71, 1.5571) (2220.35, 1.562) (2314.84, 1.5669) (2413.36, 1.5718) (2516.07, 1.5768) (2623.16, 1.5818) (2734.8, 1.5869)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}
  Arnold_Magnetics_N48SH_N: permeability{HUnit=A_per_meter BUnit=tesla curve (-1588000, -2.0648) (-1580000, -1.1262) (-1572000, -0.9299) (-1550000, -0.7568) (-1532000, -0.6908) (-1513000, -0.6446) (-1494000, -0.6068) (-1475000, -0.5733) (-1457000, -0.5424) (-1438000, -0.5131) (-1419000, -0.4849) (-1401000, -0.4574) (-1382000, -0.4306) (-1363000, -0.4041) (-1345000, -0.378) (-1326000, -0.3521) (-1307000, -0.3264) (-1289000, -0.3009) (-1270000, -0.2756) (-1251000, -0.2503) (-1233000, -0.2252) (-1214000, -0.2001) (-1195000, -0.1752) (-1177000, -0.1502) (-1158000, -0.1254) (-1139000, -0.1006) (-1121000, -0.0758) (-1102000, -0.051) (-1083000, -0.0263) (-1065000, -0.0017) (-1046000, 0.023) (-1027000, 0.0476) (-1009000, 0.0722) (-990000, 0.0968) (-971000, 0.1214) (-953000, 0.1459) (-934000, 0.1705) (-915000, 0.195) (-896000, 0.2195) (-878000, 0.244) (-859000, 0.2685) (-840000, 0.293) (-822000, 0.3175) (-803000, 0.3419) (-784000, 0.3664) (-766000, 0.3908) (-747000, 0.4153) (-728000, 0.4397) (-710000, 0.4641) (-691000, 0.4885) (-672000, 0.513) (-654000, 0.5374) (-635000, 0.5618) (-616000, 0.5862) (-598000, 0.6106) (-579000, 0.635) (-560000, 0.6594) (-542000, 0.6838) (-523000, 0.7081) (-504000, 0.7325) (-486000, 0.7569) (-467000, 0.7813) (-448000, 0.8056) (-430000, 0.83) (-411000, 0.8544) (-392000, 0.8787) (-374000, 0.9031) (-355000, 0.9275) (-336000, 0.9518) (-318000, 0.9762) (-299000, 1.0005) (-280000, 1.0249) (-261000, 1.0492) (-243000, 1.0736) (-224000, 1.0979) (-205000, 1.1223) (-187000, 1.1466) (-168000, 1.171) (-149000, 1.1953) (-131000, 1.2196) (-112000, 1.244) (-93000, 1.2683) (-75000, 1.2927) (-56000, 1.317) (-37000, 1.3413) (-19000, 1.3657) (0, 1.39)} conductivity=555555.5556 magnetic_coercivity{Magnitude=-1047400A_per_meter DirComp1=0 DirComp2=1 DirComp3=0}
  Arnold_Magnetics_N48SH_S: permeability{HUnit=A_per_meter BUnit=tesla curve (-1588000, -2.0648) (-1580000, -1.1262) (-1572000, -0.9299) (-1550000, -0.7568) (-1532000, -0.6908) (-1513000, -0.6446) (-1494000, -0.6068) (-1475000, -0.5733) (-1457000, -0.5424) (-1438000, -0.5131) (-1419000, -0.4849) (-1401000, -0.4574) (-1382000, -0.4306) (-1363000, -0.4041) (-1345000, -0.378) (-1326000, -0.3521) (-1307000, -0.3264) (-1289000, -0.3009) (-1270000, -0.2756) (-1251000, -0.2503) (-1233000, -0.2252) (-1214000, -0.2001) (-1195000, -0.1752) (-1177000, -0.1502) (-1158000, -0.1254) (-1139000, -0.1006) (-1121000, -0.0758) (-1102000, -0.051) (-1083000, -0.0263) (-1065000, -0.0017) (-1046000, 0.023) (-1027000, 0.0476) (-1009000, 0.0722) (-990000, 0.0968) (-971000, 0.1214) (-953000, 0.1459) (-934000, 0.1705) (-915000, 0.195) (-896000, 0.2195) (-878000, 0.244) (-859000, 0.2685) (-840000, 0.293) (-822000, 0.3175) (-803000, 0.3419) (-784000, 0.3664) (-766000, 0.3908) (-747000, 0.4153) (-728000, 0.4397) (-710000, 0.4641) (-691000, 0.4885) (-672000, 0.513) (-654000, 0.5374) (-635000, 0.5618) (-616000, 0.5862) (-598000, 0.6106) (-579000, 0.635) (-560000, 0.6594) (-542000, 0.6838) (-523000, 0.7081) (-504000, 0.7325) (-486000, 0.7569) (-467000, 0.7813) (-448000, 0.8056) (-430000, 0.83) (-411000, 0.8544) (-392000, 0.8787) (-374000, 0.9031) (-355000, 0.9275) (-336000, 0.9518) (-318000, 0.9762) (-299000, 1.0005) (-280000, 1.0249) (-261000, 1.0492) (-243000, 1.0736) (-224000, 1.0979) (-205000, 1.1223) (-187000, 1.1466) (-168000, 1.171) (-149000, 1.1953) (-131000, 1.2196) (-112000, 1.244) (-93000, 1.2683) (-75000, 1.2927) (-56000, 1.317) (-37000, 1.3413) (-19000, 1.3657) (0, 1.39)} conductivity=555555.5556 magnetic_coercivity{Magnitude=-1047400A_per_meter DirComp1=0 DirComp2=-1 DirComp3=0}
  copper: permeability=0.999991 conductivity=58000000

design lm (Maxwell 2D, Transient, XY geometry, model units mm)
options: ModelDepth=55mm
geometry:
  Iron [ChinaSteel_35CS210] = imported_body(C:/Users/chiso/AppData/Local/Temp/33BE2241216976171973..x_t)
  U1p, U1n, U1n_1, U1p_1, V1n, V1n_1, V1p, V1p_1, W1p, W1n, W1n_1, W1p_1, U1n_2, V1p_2, W1n_2, U1p_2, V1n_2, W1p_2, U1p_3, V1n_3, W1p_3, U1n_3, V1p_3, W1n_3, U1p_4..U1p_7, U1n_4, U1n_5, U1n_7, U1n_6, V1n_5, V1n_4, V1n_7, V1n_6, V1p_4, V1p_5, V1p_7, V1p_6, W1p_4, W1p_6, W1p_5, W1p_7, W1n_4, W1n_6, W1n_5, W1n_7, U2p, U2p_1, U2p_2, U2p_4, U2p_3, U2p_6, U2p_5, U2p_7, U2n, U2n_2, U2n_1, U2n_3, U2n_4, U2n_6, U2n_5, U2n_7, V2n, V2n_2, V2n_1, V2n_4, V2n_3, V2n_6, V2n_5, V2n_7, V2p, V2p_2, V2p_1, V2p_4, V2p_3, V2p_6, V2p_7, V2p_5, W2n_1, W2n, W2n_3, W2n_2, W2p, W2p_1, W2p_3, W2p_2, W2n_4..W2n_7, W2p_4, W2p_5, W2p_7, W2p_6 [copper] = imported_body(C:/Users/chiso/AppData/Local/Temp/33BE2241216976171973..x_t)
  Iron_1 [ChinaSteel_35CS210] = imported_body(C:/Users/chiso/AppData/Local/Temp/33BE2241216976171973..x_t)
  PM_N [Arnold_Magnetics_N48SH_N] = imported_body(C:/Users/chiso/AppData/Local/Temp/33BE2241216976171973..x_t)
  PM_S [Arnold_Magnetics_N48SH_S] = imported_body(C:/Users/chiso/AppData/Local/Temp/33BE2241216976171973..x_t)
  PM_N_1 [Arnold_Magnetics_N48SH_N] = imported_body(C:/Users/chiso/AppData/Local/Temp/33BE2241216976171973..x_t)
  PM_S_1 [Arnold_Magnetics_N48SH_S] = imported_body(C:/Users/chiso/AppData/Local/Temp/33BE2241216976171973..x_t)
  PM_N_2 [Arnold_Magnetics_N48SH_N] = imported_body(C:/Users/chiso/AppData/Local/Temp/33BE2241216976171973..x_t)
  PM_S_2 [Arnold_Magnetics_N48SH_S] = imported_body(C:/Users/chiso/AppData/Local/Temp/33BE2241216976171973..x_t)
  PM_N_3 [Arnold_Magnetics_N48SH_N] = imported_body(C:/Users/chiso/AppData/Local/Temp/33BE2241216976171973..x_t)
  PM_S_4 [Arnold_Magnetics_N48SH_S] = imported_body(C:/Users/chiso/AppData/Local/Temp/33BE2241216976171973..x_t)
  PM_N_4 [Arnold_Magnetics_N48SH_N] = imported_body(C:/Users/chiso/AppData/Local/Temp/33BE2241216976171973..x_t)
  PM_S_3 [Arnold_Magnetics_N48SH_S] = imported_body(C:/Users/chiso/AppData/Local/Temp/33BE2241216976171973..x_t)
  air1 [vacuum] = rectangle(corner=(20.8332mm, 2mm, 0mm), x_size=99mm, y_size=-4mm)
  Air2 [vacuum] = rectangle(corner=(-5mm, 20mm, 0mm), x_size=215mm, y_size=-40mm)
  band [vacuum] = rectangle(corner=(0mm, 2.5mm, 0mm), x_size=204mm, y_size=-5mm)
motion:
  MotionSetup1: Band Move_Type=Translate Coordinate_System=Global PostProcessing_Coordinate_System=Global Axis=X Is_Positive=true InitPos=0mm NegativePos=0mm PositivePos=60mm Velocity=2m_per_sec Objects=band
  Moving1: Moving Objects=[PM_N, PM_S, PM_N_1, PM_S_1, PM_N_2, PM_S_2, PM_N_3, PM_S_4, PM_N_4, PM_S_3, air1]
boundaries and excitations:
  VectorPotential1: Vector Potential Edges=Air2.edge(all 4) Value=0
  U1n: Coil Objects=U1n Conductor_number=10 Winding=WindingU1 PolarityType=Negative
  U1n_1: Coil Objects=U1n_1 Conductor_number=10 Winding=WindingU1 PolarityType=Negative
  U1n_2: Coil Objects=U1n_2 Conductor_number=10 Winding=WindingU1 PolarityType=Negative
  U1n_3: Coil Objects=U1n_3 Conductor_number=10 Winding=WindingU1 PolarityType=Negative
  U1n_4: Coil Objects=U1n_4 Conductor_number=10 Winding=WindingU1 PolarityType=Negative
  U1n_5: Coil Objects=U1n_5 Conductor_number=10 Winding=WindingU1 PolarityType=Negative
  U1n_6: Coil Objects=U1n_6 Conductor_number=10 Winding=WindingU1 PolarityType=Negative
  U1n_7: Coil Objects=U1n_7 Conductor_number=10 Winding=WindingU1 PolarityType=Negative
  U1p: Coil Objects=U1p Conductor_number=10 Winding=WindingU1 PolarityType=Positive
  U1p_1: Coil Objects=U1p_1 Conductor_number=10 Winding=WindingU1 PolarityType=Positive
  U1p_2: Coil Objects=U1p_2 Conductor_number=10 Winding=WindingU1 PolarityType=Positive
  U1p_3: Coil Objects=U1p_3 Conductor_number=10 Winding=WindingU1 PolarityType=Positive
  U1p_4: Coil Objects=U1p_4 Conductor_number=10 Winding=WindingU1 PolarityType=Positive
  U1p_5: Coil Objects=U1p_5 Conductor_number=10 Winding=WindingU1 PolarityType=Positive
  U1p_6: Coil Objects=U1p_6 Conductor_number=10 Winding=WindingU1 PolarityType=Positive
  U1p_7: Coil Objects=U1p_7 Conductor_number=10 Winding=WindingU1 PolarityType=Positive
  U2n: Coil Objects=U2n Conductor_number=10 Winding=WindingU2 PolarityType=Negative
  U2n_1: Coil Objects=U2n_1 Conductor_number=10 Winding=WindingU2 PolarityType=Negative
  U2n_2: Coil Objects=U2n_2 Conductor_number=10 Winding=WindingU2 PolarityType=Negative
  U2n_3: Coil Objects=U2n_3 Conductor_number=10 Winding=WindingU2 PolarityType=Negative
  U2n_4: Coil Objects=U2n_4 Conductor_number=10 Winding=WindingU2 PolarityType=Negative
  U2n_5: Coil Objects=U2n_5 Conductor_number=10 Winding=WindingU2 PolarityType=Negative
  U2n_6: Coil Objects=U2n_6 Conductor_number=10 Winding=WindingU2 PolarityType=Negative
  U2n_7: Coil Objects=U2n_7 Conductor_number=10 Winding=WindingU2 PolarityType=Negative
  U2p: Coil Objects=U2p Conductor_number=10 Winding=WindingU2 PolarityType=Positive
  U2p_1: Coil Objects=U2p_1 Conductor_number=10 Winding=WindingU2 PolarityType=Positive
  U2p_2: Coil Objects=U2p_2 Conductor_number=10 Winding=WindingU2 PolarityType=Positive
  U2p_3: Coil Objects=U2p_3 Conductor_number=10 Winding=WindingU2 PolarityType=Positive
  U2p_4: Coil Objects=U2p_4 Conductor_number=10 Winding=WindingU2 PolarityType=Positive
  U2p_5: Coil Objects=U2p_5 Conductor_number=10 Winding=WindingU2 PolarityType=Positive
  U2p_6: Coil Objects=U2p_6 Conductor_number=10 Winding=WindingU2 PolarityType=Positive
  U2p_7: Coil Objects=U2p_7 Conductor_number=10 Winding=WindingU2 PolarityType=Positive
  V1n: Coil Objects=V1n Conductor_number=10 Winding=WindingV1 PolarityType=Negative
  V1n_1: Coil Objects=V1n_1 Conductor_number=10 Winding=WindingV1 PolarityType=Negative
  V1n_2: Coil Objects=V1n_2 Conductor_number=10 Winding=WindingV1 PolarityType=Negative
  V1n_3: Coil Objects=V1n_3 Conductor_number=10 Winding=WindingV1 PolarityType=Negative
  V1n_4: Coil Objects=V1n_4 Conductor_number=10 Winding=WindingV1 PolarityType=Negative
  V1n_5: Coil Objects=V1n_5 Conductor_number=10 Winding=WindingV1 PolarityType=Negative
  V1n_6: Coil Objects=V1n_6 Conductor_number=10 Winding=WindingV1 PolarityType=Negative
  V1n_7: Coil Objects=V1n_7 Conductor_number=10 Winding=WindingV1 PolarityType=Negative
  V1p: Coil Objects=V1p Conductor_number=10 Winding=WindingV1 PolarityType=Positive
  V1p_1: Coil Objects=V1p_1 Conductor_number=10 Winding=WindingV1 PolarityType=Positive
  V1p_2: Coil Objects=V1p_2 Conductor_number=10 Winding=WindingV1 PolarityType=Positive
  V1p_3: Coil Objects=V1p_3 Conductor_number=10 Winding=WindingV1 PolarityType=Positive
  V1p_4: Coil Objects=V1p_4 Conductor_number=10 Winding=WindingV1 PolarityType=Positive
  V1p_5: Coil Objects=V1p_5 Conductor_number=10 Winding=WindingV1 PolarityType=Positive
  V1p_6: Coil Objects=V1p_6 Conductor_number=10 Winding=WindingV1 PolarityType=Positive
  V1p_7: Coil Objects=V1p_7 Conductor_number=10 Winding=WindingV1 PolarityType=Positive
  V2n: Coil Objects=V2n Conductor_number=10 Winding=WindingV2 PolarityType=Negative
  V2n_1: Coil Objects=V2n_1 Conductor_number=10 Winding=WindingV2 PolarityType=Negative
  V2n_2: Coil Objects=V2n_2 Conductor_number=10 Winding=WindingV2 PolarityType=Negative
  V2n_3: Coil Objects=V2n_3 Conductor_number=10 Winding=WindingV2 PolarityType=Negative
  V2n_4: Coil Objects=V2n_4 Conductor_number=10 Winding=WindingV2 PolarityType=Negative
  V2n_5: Coil Objects=V2n_5 Conductor_number=10 Winding=WindingV2 PolarityType=Negative
  V2n_6: Coil Objects=V2n_6 Conductor_number=10 Winding=WindingV2 PolarityType=Negative
  V2n_7: Coil Objects=V2n_7 Conductor_number=10 Winding=WindingV2 PolarityType=Negative
  V2p: Coil Objects=V2p Conductor_number=10 Winding=WindingV2 PolarityType=Positive
  V2p_1: Coil Objects=V2p_1 Conductor_number=10 Winding=WindingV2 PolarityType=Positive
  V2p_2: Coil Objects=V2p_2 Conductor_number=10 Winding=WindingV2 PolarityType=Positive
  V2p_3: Coil Objects=V2p_3 Conductor_number=10 Winding=WindingV2 PolarityType=Positive
  V2p_4: Coil Objects=V2p_4 Conductor_number=10 Winding=WindingV2 PolarityType=Positive
  V2p_5: Coil Objects=V2p_5 Conductor_number=10 Winding=WindingV2 PolarityType=Positive
  V2p_6: Coil Objects=V2p_6 Conductor_number=10 Winding=WindingV2 PolarityType=Positive
  V2p_7: Coil Objects=V2p_7 Conductor_number=10 Winding=WindingV2 PolarityType=Positive
  W1n: Coil Objects=W1n Conductor_number=10 Winding=WindingW1 PolarityType=Negative
  W1n_1: Coil Objects=W1n_1 Conductor_number=10 Winding=WindingW1 PolarityType=Negative
  W1n_2: Coil Objects=W1n_2 Conductor_number=10 Winding=WindingW1 PolarityType=Negative
  W1n_3: Coil Objects=W1n_3 Conductor_number=10 Winding=WindingW1 PolarityType=Negative
  W1n_4: Coil Objects=W1n_4 Conductor_number=10 Winding=WindingW1 PolarityType=Negative
  W1n_5: Coil Objects=W1n_5 Conductor_number=10 Winding=WindingW1 PolarityType=Negative
  W1n_6: Coil Objects=W1n_6 Conductor_number=10 Winding=WindingW1 PolarityType=Negative
  W1n_7: Coil Objects=W1n_7 Conductor_number=10 Winding=WindingW1 PolarityType=Negative
  W1p: Coil Objects=W1p Conductor_number=10 Winding=WindingW1 PolarityType=Positive
  W1p_1: Coil Objects=W1p_1 Conductor_number=10 Winding=WindingW1 PolarityType=Positive
  W1p_2: Coil Objects=W1p_2 Conductor_number=10 Winding=WindingW1 PolarityType=Positive
  W1p_3: Coil Objects=W1p_3 Conductor_number=10 Winding=WindingW1 PolarityType=Positive
  W1p_4: Coil Objects=W1p_4 Conductor_number=10 Winding=WindingW1 PolarityType=Positive
  W1p_5: Coil Objects=W1p_5 Conductor_number=10 Winding=WindingW1 PolarityType=Positive
  W1p_6: Coil Objects=W1p_6 Conductor_number=10 Winding=WindingW1 PolarityType=Positive
  W1p_7: Coil Objects=W1p_7 Conductor_number=10 Winding=WindingW1 PolarityType=Positive
  W2n_1: Coil Objects=W2n Conductor_number=10 Winding=WindingW2 PolarityType=Negative
  W2n_2: Coil Objects=W2n_1 Conductor_number=10 Winding=WindingW2 PolarityType=Negative
  W2n_3: Coil Objects=W2n_2 Conductor_number=10 Winding=WindingW2 PolarityType=Negative
  W2n_4: Coil Objects=W2n_3 Conductor_number=10 Winding=WindingW2 PolarityType=Negative
  W2n_5: Coil Objects=W2n_4 Conductor_number=10 Winding=WindingW2 PolarityType=Negative
  W2n_6: Coil Objects=W2n_5 Conductor_number=10 Winding=WindingW2 PolarityType=Negative
  W2n_7: Coil Objects=W2n_6 Conductor_number=10 Winding=WindingW2 PolarityType=Negative
  W2n_8: Coil Objects=W2n_7 Conductor_number=10 Winding=WindingW2 PolarityType=Negative
  W2p: Coil Objects=W2p Conductor_number=10 Winding=WindingW2 PolarityType=Positive
  W2p_1: Coil Objects=W2p_1 Conductor_number=10 Winding=WindingW2 PolarityType=Positive
  W2p_2: Coil Objects=W2p_2 Conductor_number=10 Winding=WindingW2 PolarityType=Positive
  W2p_3: Coil Objects=W2p_3 Conductor_number=10 Winding=WindingW2 PolarityType=Positive
  W2p_4: Coil Objects=W2p_4 Conductor_number=10 Winding=WindingW2 PolarityType=Positive
  W2p_5: Coil Objects=W2p_5 Conductor_number=10 Winding=WindingW2 PolarityType=Positive
  W2p_6: Coil Objects=W2p_6 Conductor_number=10 Winding=WindingW2 PolarityType=Positive
  W2p_7: Coil Objects=W2p_7 Conductor_number=10 Winding=WindingW2 PolarityType=Positive
  WindingU1: Winding Group Type=Current IsSolid=false Current=11*sin(2*pi*100*Time) ParallelBranchesNum=1
  WindingV1: Winding Group Type=Current IsSolid=false Current=11*sin(2*pi*100*Time-2*pi/3) ParallelBranchesNum=1
  WindingW1: Winding Group Type=Current IsSolid=false Current=11*sin(2*pi*100*Time+2*pi/3) ParallelBranchesNum=1
  WindingU2: Winding Group Type=Current IsSolid=false Current=11*sin(2*pi*100*Time) ParallelBranchesNum=1
  WindingV2: Winding Group Type=Current IsSolid=false Current=11*sin(2*pi*100*Time-2*pi/3) ParallelBranchesNum=1
  WindingW2: Winding Group Type=Current IsSolid=false Current=11*sin(2*pi*100*Time+2*pi/3) ParallelBranchesNum=1
parameters:
  Force_PM: Force Reference_CS=Global Objects=[PM_S_3, PM_N_4, PM_S_4, PM_N_3, PM_S_2, PM_N_2, PM_S_1, PM_N_1, PM_S, PM_N]
mesh:
  coils: LengthBased RefineInside Objects=[U1n, U1n_1..U1n_7, U1p, U1p_1..U1p_7, U2n, U2n_1..U2n_7, U2p, U2p_1..U2p_7, V1n, V1n_1..V1n_7, V1p, V1p_1..V1p_7, V2n, V2n_1..V2n_7, V2p, V2p_1..V2p_7, W1n, W1n_1..W1n_7, W1p, W1p_1..W1p_7, W2n, W2n_1..W2n_7, W2p, W2p_1..W2p_7] MaxLength=1mm
  iron: LengthBased RefineInside Objects=[Iron, Iron_1] MaxLength=1mm
  pm: LengthBased RefineInside Objects=[PM_N, PM_N_1..PM_N_4, PM_S, PM_S_1..PM_S_4] MaxLength=1mm
  Region: LengthBased RefineInside Objects=Air2 MaxLength=1mm
  air: LengthBased Objects=air1 MaxLength=0.5mm
  band: LengthBased Objects=band MaxLength=0.5mm
setups:
  Setup1: Transient NonlinearSolverResidual=0.0001 StopTime=0.02s TimeStep="(0.01/100) s" InitialTimeStep=0.002s MinTimeStep=0.001s MaxTimeStep=0.003s TimeStepErrTolerance=0.0001
reports:
  Thrust: Force_PM.Force_x vs Time on Setup1 : Transient
  InducedVoltage1: InducedVoltage(WindingU1), InducedVoltage(WindingV1), InducedVoltage(WindingW1) vs Time on Setup1 : Transient
  InducedVoltage2: InducedVoltage(WindingU2), InducedVoltage(WindingV2), InducedVoltage(WindingW2) vs Time on Setup1 : Transient
  Fluxlinkage1: FluxLinkage(WindingU1), FluxLinkage(WindingV1), FluxLinkage(WindingW1) vs Time on Setup1 : Transient
  Fluxlinkage2: FluxLinkage(WindingU2), FluxLinkage(WindingV2), FluxLinkage(WindingW2) vs Time on Setup1 : Transient
  Current1: InputCurrent(WindingU1), InputCurrent(WindingV1), InputCurrent(WindingW1) vs Time on Setup1 : Transient
  Current2: InputCurrent(WindingU2), InputCurrent(WindingV2), InputCurrent(WindingW2) vs Time on Setup1 : Transient
